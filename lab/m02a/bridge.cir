* M02a: jembatan Wheatstone, analisis titik kerja DC
VS 1 0 DC 5
R1 1 2 1k
R2 2 0 2k
R3 1 3 1.5k
R4 3 0 1k
R5 2 3 500
.control
op
print v(1) v(2) v(3)
print i(vs)
print (v(2)-v(3))/500
.endc
.end
